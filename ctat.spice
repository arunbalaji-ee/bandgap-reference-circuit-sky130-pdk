** sch_path: /home/arunbalaji/projects/ctat.sch
**.subckt ctat
XQ1 0 0 net1 sky130_fd_pr__pnp_05v5_W3p40L3p40 m=1 mult=1
I0 VDD net1 1m
V1 VDD 0 1.8
**** begin user architecture code

.lib /home/arunbalaji/open_pdks/sky130/sky130A/libs.tech/ngspice/sky130.lib.spice tt
.control
dc temp -40 80 1
run

* Plot V_BE
plot v(net1)

* Plot dV/dT
plot deriv(v(net1))

.endc

**** end user architecture code
**.ends
.GLOBAL VDD
.end
